// ============================================================================
// uart - Register Definition Language (SystemRDL)
// IP: uart
// Version: 0.1.0
// Bus: TL-UL / APB4 (via apb2tlul wrapper), 32-bit data, 6-bit block address
// Source: OpenTitan hw/ip/uart/data/uart.hjson (Apache-2.0)
// NOTE: This RDL is the authoritative register specification for documentation,
// C header, HTML and IP-XACT RAL generation. The core RTL keeps the original
// OpenTitan generated uart_reg_top.sv / uart_reg_pkg.sv unchanged.
// ============================================================================

addrmap uart {
    desc = "Universal Asynchronous Receiver/Transmitter (UART) full duplex serial communication interface";

    // ========================================================================
    // Enumerated types
    // ========================================================================
    enum rxblvl_e {
        BREAK2 = 0 { desc = "2 characters"; };
        BREAK4 = 1 { desc = "4 characters"; };
        BREAK8 = 2 { desc = "8 characters"; };
        BREAK16 = 3 { desc = "16 characters"; };
    };

    enum rxlvl_e {
        RXLVL1 = 0 { desc = "1 character"; };
        RXLVL2 = 1 { desc = "2 characters"; };
        RXLVL4 = 2 { desc = "4 characters"; };
        RXLVL8 = 3 { desc = "8 characters"; };
        RXLVL16 = 4 { desc = "16 characters"; };
        RXLVL32 = 5 { desc = "32 characters"; };
        RXLVL62 = 6 { desc = "62 characters"; };
    };

    enum txlvl_e {
        TXLVL1 = 0 { desc = "1 character"; };
        TXLVL2 = 1 { desc = "2 characters"; };
        TXLVL4 = 2 { desc = "4 characters"; };
        TXLVL8 = 3 { desc = "8 characters"; };
        TXLVL16 = 4 { desc = "16 characters"; };
    };

    // ========================================================================
    // CTRL (0x00) - UART control register
    // ========================================================================
    reg {
        desc = "UART control register";
        default sw = rw;
        default hw = r;

        field {} TX[0:0];
        field {} RX[1:1];
        field {} NF[2:2];
        field {} SLPBK[4:4];
        field {} LLPBK[5:5];
        field {} PARITY_EN[6:6];
        field {} PARITY_ODD[7:7];
        field {
            encode = rxblvl_e;
        } RXBLVL[9:8];
        field {} NCO[31:16];
    } CTRL @ 0x000;

    // ========================================================================
    // STATUS (0x04) - UART live status register (hardware driven)
    // ========================================================================
    reg {
        desc = "UART live status register";
        default sw = r;
        default hw = rw;

        field {} TXFULL[0:0];
        field {} RXFULL[1:1];
        field { reset = 1'b1; } TXEMPTY[2:2];
        field { reset = 1'b1; } TXIDLE[3:3];
        field { reset = 1'b1; } RXIDLE[4:4];
        field { reset = 1'b1; } RXEMPTY[5:5];
    } STATUS @ 0x004;

    // ========================================================================
    // RDATA (0x08) - UART read data (hardware driven)
    // ========================================================================
    reg {
        desc = "UART read data";
        default sw = r;
        default hw = rw;

        field {} DATA[7:0];
    } RDATA @ 0x008;

    // ========================================================================
    // WDATA (0x0C) - UART write data (write only, hardware reads)
    // ========================================================================
    reg {
        desc = "UART write data";
        default sw = w;
        default hw = r;

        field {} DATA[7:0];
    } WDATA @ 0x00C;

    // ========================================================================
    // FIFO_CTRL (0x10) - UART FIFO control register
    // ========================================================================
    reg {
        desc = "UART FIFO control register";
        default sw = rw;
        default hw = r;

        field {
            sw = w;
            hw = r;
            onwrite = woset;
        } RXRST[0:0];
        field {
            sw = w;
            hw = r;
            onwrite = woset;
        } TXRST[1:1];
        field {
            encode = rxlvl_e;
        } RXILVL[4:2];
        field {
            encode = txlvl_e;
        } TXILVL[7:5];
    } FIFO_CTRL @ 0x010;

    // ========================================================================
    // FIFO_STATUS (0x14) - UART FIFO status register (hardware driven)
    // ========================================================================
    reg {
        desc = "UART FIFO status register";
        default sw = r;
        default hw = rw;

        field {} TXLVL[7:0];
        field {} RXLVL[23:16];
    } FIFO_STATUS @ 0x014;

    // ========================================================================
    // OVRD (0x18) - TX pin override control
    // ========================================================================
    reg {
        desc = "TX pin override control";
        default sw = rw;
        default hw = r;

        field {} TXEN[0:0];
        field {} TXVAL[1:1];
    } OVRD @ 0x018;

    // ========================================================================
    // VAL (0x1C) - UART oversampled values (hardware driven)
    // ========================================================================
    reg {
        desc = "UART oversampled values";
        default sw = r;
        default hw = rw;

        field {} RX[15:0];
    } VAL @ 0x01C;

    // ========================================================================
    // TIMEOUT_CTRL (0x20) - UART RX timeout control
    // ========================================================================
    reg {
        desc = "UART RX timeout control";
        default sw = rw;
        default hw = r;

        field {} VAL[23:0];
        field {} EN[31:31];
    } TIMEOUT_CTRL @ 0x020;

    // ========================================================================
    // INTR_STATE (0x24) - Interrupt state register (W1C, hardware set)
    // ========================================================================
    reg {
        desc = "Interrupt state register";
        default sw = w;
        default hw = rw;

        field { onwrite = wclr; precedence = hw; hwset; } tx_empty[0:0];
        field { onwrite = wclr; precedence = hw; hwset; } rx_parity_err[1:1];
        field { onwrite = wclr; precedence = hw; hwset; } rx_timeout[2:2];
        field { onwrite = wclr; precedence = hw; hwset; } rx_break_err[3:3];
        field { onwrite = wclr; precedence = hw; hwset; } rx_frame_err[4:4];
        field { onwrite = wclr; precedence = hw; hwset; } rx_overflow[5:5];
        field { onwrite = wclr; precedence = hw; hwset; } tx_done[6:6];
        field { onwrite = wclr; precedence = hw; hwset; } rx_watermark[7:7];
        field { onwrite = wclr; precedence = hw; hwset; } tx_watermark[8:8];
    } INTR_STATE @ 0x024;

    // ========================================================================
    // INTR_ENABLE (0x28) - Interrupt enable register
    // ========================================================================
    reg {
        desc = "Interrupt enable register";
        default sw = rw;
        default hw = r;

        field {} tx_empty[0:0];
        field {} rx_parity_err[1:1];
        field {} rx_timeout[2:2];
        field {} rx_break_err[3:3];
        field {} rx_frame_err[4:4];
        field {} rx_overflow[5:5];
        field {} tx_done[6:6];
        field {} rx_watermark[7:7];
        field {} tx_watermark[8:8];
    } INTR_ENABLE @ 0x028;

    // ========================================================================
    // INTR_TEST (0x2C) - Interrupt test register (software write sets state)
    // ========================================================================
    reg {
        desc = "Interrupt test register";
        default sw = rw;
        default hw = r;

        field { onwrite = wset; precedence = sw; } tx_empty[0:0];
        field { onwrite = wset; precedence = sw; } rx_parity_err[1:1];
        field { onwrite = wset; precedence = sw; } rx_timeout[2:2];
        field { onwrite = wset; precedence = sw; } rx_break_err[3:3];
        field { onwrite = wset; precedence = sw; } rx_frame_err[4:4];
        field { onwrite = wset; precedence = sw; } rx_overflow[5:5];
        field { onwrite = wset; precedence = sw; } tx_done[6:6];
        field { onwrite = wset; precedence = sw; } rx_watermark[7:7];
        field { onwrite = wset; precedence = sw; } tx_watermark[8:8];
    } INTR_TEST @ 0x02C;

    // ========================================================================
    // INTR_STATUS (0x30) - Interrupt status register (state & enable)
    // ========================================================================
    reg {
        desc = "Interrupt status register";
        default sw = r;
        default hw = rw;

        field {} tx_empty[0:0];
        field {} rx_parity_err[1:1];
        field {} rx_timeout[2:2];
        field {} rx_break_err[3:3];
        field {} rx_frame_err[4:4];
        field {} rx_overflow[5:5];
        field {} tx_done[6:6];
        field {} rx_watermark[7:7];
        field {} tx_watermark[8:8];
    } INTR_STATUS @ 0x030;

    // ========================================================================
    // ALERT_TEST (0x34) - Alert test register
    // ========================================================================
    reg {
        desc = "Alert test register";
        default sw = rw;
        default hw = r;

        field { onwrite = woset; precedence = sw; } fatal_fault[0:0];
    } ALERT_TEST @ 0x034;
};

// Register structure source. External storage follows docs/lld/implementation.md.
addrmap watchdog_regs {
    external reg {desc="IP_ID"; field {sw=r; hw=w; reset=32'h57445431;} value_0[31:0];} IP_ID @ 0x000;
    external reg {desc="VERSION"; field {sw=r; hw=w; reset=32'h00010000;} value_0[31:0];} VERSION @ 0x004;
    external reg {desc="CAPABILITY0"; field {sw=r; hw=w; reset=32'h00410000;} value_0[31:0];} CAPABILITY0 @ 0x008;
    external reg {desc="CAPABILITY1"; field {sw=r; hw=w; reset=0;} value_0[31:0];} CAPABILITY1 @ 0x00c;
    external reg {desc="CMD_STATUS"; field {sw=r; hw=w; reset=0;} value_0[31:0];} CMD_STATUS @ 0x010;
    external reg {desc="ISSUED_SEQ"; field {sw=r; hw=w; reset=0;} value_0[31:0];} ISSUED_SEQ @ 0x014;
    external reg {desc="DONE_SEQ"; field {sw=r; hw=w; reset=0;} value_0[31:0];} DONE_SEQ @ 0x018;
    external reg {desc="DONE_INFO"; field {sw=r; hw=w; reset=0;} value_0[31:0];} DONE_INFO @ 0x01c;
    external reg {desc="IRQ_SUMMARY"; field {sw=r; hw=w; reset=0;} value_0[31:0];} IRQ_SUMMARY @ 0x020;
    external reg {desc="FAULT_SUMMARY"; field {sw=r; hw=w; reset=0;} value_0[31:0];} FAULT_SUMMARY @ 0x024;
    external reg {desc="RESET_SUMMARY"; field {sw=r; hw=w; reset=0;} value_0[31:0];} RESET_SUMMARY @ 0x028;
  regfile channel_regs {
    external reg {desc="CTRL_STAGE"; field {sw=rw; hw=r; reset=32'h0000000c;} value_0[12:0];} CTRL_STAGE @ 0x000;
    external reg {desc="PRESCALE_STAGE"; field {sw=rw; hw=r; reset=0;} value_0[31:0];} PRESCALE_STAGE @ 0x004;
    external reg {desc="WIN_MIN_LO_STAGE"; field {sw=rw; hw=r; reset=0;} value_0[31:0];} WIN_MIN_LO_STAGE @ 0x008;
    external reg {desc="WIN_MIN_HI_STAGE"; field {sw=rw; hw=r; reset=0;} value_0[31:0];} WIN_MIN_HI_STAGE @ 0x00c;
    external reg {desc="TIMEOUT_LO_STAGE"; field {sw=rw; hw=r; reset=32'h00010000;} value_0[31:0];} TIMEOUT_LO_STAGE @ 0x010;
    external reg {desc="TIMEOUT_HI_STAGE"; field {sw=rw; hw=r; reset=0;} value_0[31:0];} TIMEOUT_HI_STAGE @ 0x014;
    external reg {desc="PRETIMEOUT_LO_STAGE"; field {sw=rw; hw=r; reset=0;} value_0[31:0];} PRETIMEOUT_LO_STAGE @ 0x018;
    external reg {desc="PRETIMEOUT_HI_STAGE"; field {sw=rw; hw=r; reset=0;} value_0[31:0];} PRETIMEOUT_HI_STAGE @ 0x01c;
    external reg {desc="BOOT_TIMEOUT_LO_STAGE"; field {sw=rw; hw=r; reset=32'h00010000;} value_0[31:0];} BOOT_TIMEOUT_LO_STAGE @ 0x020;
    external reg {desc="BOOT_TIMEOUT_HI_STAGE"; field {sw=rw; hw=r; reset=0;} value_0[31:0];} BOOT_TIMEOUT_HI_STAGE @ 0x024;
    external reg {desc="SEQ_LIMIT_STAGE"; field {sw=rw; hw=r; reset=32'h00000100;} value_0[31:0];} SEQ_LIMIT_STAGE @ 0x028;
    external reg {desc="REQUIRE_MASK_STAGE"; field {sw=rw; hw=r; reset=32'h00000001;} value_0[31:0];} REQUIRE_MASK_STAGE @ 0x02c;
    external reg {desc="FAULT_POLICY_STAGE"; field {sw=rw; hw=r; reset=32'h000001ef;} value_1[10:1];} FAULT_POLICY_STAGE @ 0x030;
    external reg {desc="LOCAL_DELAY_STAGE"; field {sw=rw; hw=r; reset=0;} value_0[31:0];} LOCAL_DELAY_STAGE @ 0x034;
    external reg {desc="FINAL_DELAY_STAGE"; field {sw=rw; hw=r; reset=0;} value_0[31:0];} FINAL_DELAY_STAGE @ 0x038;
    external reg {desc="RECOVERY_LIMIT_STAGE"; field {sw=rw; hw=r; reset=0;} value_0[7:0];} RECOVERY_LIMIT_STAGE @ 0x03c;
    external reg {desc="UNLOCK"; field {sw=w; hw=r; reset=0;} value_0[31:0];} UNLOCK @ 0x040;
    external reg {desc="COMMAND"; field {sw=w; hw=r; reset=0;} value_0[7:0];} COMMAND @ 0x044;
    external reg {desc="LOCK_SET"; field {sw=w; hw=r; reset=0;} value_0[3:0];} LOCK_SET @ 0x048;
    external reg {desc="SERVICE_SELECT"; field {sw=rw; hw=r; reset=0;} value_0[4:0]; field {sw=rw; hw=r; reset=0;} value_8[10:8];} SERVICE_SELECT @ 0x04c;
    external reg {desc="SERVICE"; field {sw=w; hw=r; reset=0;} value_0[31:0];} SERVICE @ 0x050;
    external reg {desc="IRQ_ENABLE"; field {sw=w; hw=r; reset=0;} value_0[18:0];} IRQ_ENABLE @ 0x054;
    external reg {desc="IRQ_CLEAR"; field {sw=w; hw=r; reset=0;} value_0[18:0];} IRQ_CLEAR @ 0x058;
    external reg {desc="IRQ_TEST"; field {sw=w; hw=r; reset=0;} value_0[0:0];} IRQ_TEST @ 0x05c;
    external reg {desc="DIAG_CLEAR"; field {sw=w; hw=r; reset=0;} value_0[1:0];} DIAG_CLEAR @ 0x060;
    external reg {desc="FAULT_INJECT"; field {sw=w; hw=r; reset=0;} value_0[9:0];} FAULT_INJECT @ 0x064;
    external reg {desc="SNAP_META"; field {sw=r; hw=w; reset=0;} value_0[0:0];} SNAP_META @ 0x068;
    external reg {desc="SNAP_SEQ"; field {sw=r; hw=w; reset=0;} value_0[31:0];} SNAP_SEQ @ 0x06c;
    external reg {desc="STATUS_SNAP"; field {sw=r; hw=w; reset=0;} value_0[31:0];} STATUS_SNAP @ 0x070;
    external reg {desc="CFG_VERSION_SNAP"; field {sw=r; hw=w; reset=0;} value_0[31:0];} CFG_VERSION_SNAP @ 0x074;
    external reg {desc="COUNT_LO_SNAP"; field {sw=r; hw=w; reset=0;} value_0[31:0];} COUNT_LO_SNAP @ 0x078;
    external reg {desc="COUNT_HI_SNAP"; field {sw=r; hw=w; reset=0;} value_0[31:0];} COUNT_HI_SNAP @ 0x07c;
    external reg {desc="EVENT_RAW_SNAP"; field {sw=r; hw=w; reset=0;} value_0[31:0];} EVENT_RAW_SNAP @ 0x080;
    external reg {desc="IRQ_ENABLE_SNAP"; field {sw=r; hw=w; reset=0;} value_0[31:0];} IRQ_ENABLE_SNAP @ 0x084;
    external reg {desc="SEEN_MASK_SNAP"; field {sw=r; hw=w; reset=0;} value_0[31:0];} SEEN_MASK_SNAP @ 0x088;
    external reg {desc="MISSING_MASK_SNAP"; field {sw=r; hw=w; reset=0;} value_0[31:0];} MISSING_MASK_SNAP @ 0x08c;
    external reg {desc="LAST_SERVICE_SEQ_SNAP"; field {sw=r; hw=w; reset=0;} value_0[31:0];} LAST_SERVICE_SEQ_SNAP @ 0x090;
    external reg {desc="FAULT_COUNT_SNAP"; field {sw=r; hw=w; reset=0;} value_0[31:0];} FAULT_COUNT_SNAP @ 0x094;
    external reg {desc="RECOVERY_COUNT_SNAP"; field {sw=r; hw=w; reset=0;} value_0[31:0];} RECOVERY_COUNT_SNAP @ 0x098;
    external reg {desc="ESC_AGE_SNAP"; field {sw=r; hw=w; reset=0;} value_0[31:0];} ESC_AGE_SNAP @ 0x09c;
    external reg {desc="FIRST_FLAGS_SNAP"; field {sw=r; hw=w; reset=0;} value_0[31:0];} FIRST_FLAGS_SNAP @ 0x0a0;
    external reg {desc="FIRST_CAUSE_SNAP"; field {sw=r; hw=w; reset=0;} value_0[31:0];} FIRST_CAUSE_SNAP @ 0x0a4;
    external reg {desc="FIRST_COUNT_LO_SNAP"; field {sw=r; hw=w; reset=0;} value_0[31:0];} FIRST_COUNT_LO_SNAP @ 0x0a8;
    external reg {desc="FIRST_COUNT_HI_SNAP"; field {sw=r; hw=w; reset=0;} value_0[31:0];} FIRST_COUNT_HI_SNAP @ 0x0ac;
    external reg {desc="FIRST_SOURCE_SNAP"; field {sw=r; hw=w; reset=0;} value_0[31:0];} FIRST_SOURCE_SNAP @ 0x0b0;
    external reg {desc="FIRST_CFG_VERSION_SNAP"; field {sw=r; hw=w; reset=0;} value_0[31:0];} FIRST_CFG_VERSION_SNAP @ 0x0b4;
    external reg {desc="FIRST_MISSING_SNAP"; field {sw=r; hw=w; reset=0;} value_0[31:0];} FIRST_MISSING_SNAP @ 0x0b8;
    external reg {desc="FIRST_SERVICE_SEQ_SNAP"; field {sw=r; hw=w; reset=0;} value_0[31:0];} FIRST_SERVICE_SEQ_SNAP @ 0x0bc;
    external reg {desc="FIRST_STATE_SNAP"; field {sw=r; hw=w; reset=0;} value_0[31:0];} FIRST_STATE_SNAP @ 0x0c0;
    external reg {desc="CTRL_ACTIVE_SNAP"; field {sw=r; hw=w; reset=0;} value_0[31:0];} CTRL_ACTIVE_SNAP @ 0x100;
    external reg {desc="PRESCALE_ACTIVE_SNAP"; field {sw=r; hw=w; reset=0;} value_0[31:0];} PRESCALE_ACTIVE_SNAP @ 0x104;
    external reg {desc="WIN_MIN_LO_ACTIVE_SNAP"; field {sw=r; hw=w; reset=0;} value_0[31:0];} WIN_MIN_LO_ACTIVE_SNAP @ 0x108;
    external reg {desc="WIN_MIN_HI_ACTIVE_SNAP"; field {sw=r; hw=w; reset=0;} value_0[31:0];} WIN_MIN_HI_ACTIVE_SNAP @ 0x10c;
    external reg {desc="TIMEOUT_LO_ACTIVE_SNAP"; field {sw=r; hw=w; reset=0;} value_0[31:0];} TIMEOUT_LO_ACTIVE_SNAP @ 0x110;
    external reg {desc="TIMEOUT_HI_ACTIVE_SNAP"; field {sw=r; hw=w; reset=0;} value_0[31:0];} TIMEOUT_HI_ACTIVE_SNAP @ 0x114;
    external reg {desc="PRETIMEOUT_LO_ACTIVE_SNAP"; field {sw=r; hw=w; reset=0;} value_0[31:0];} PRETIMEOUT_LO_ACTIVE_SNAP @ 0x118;
    external reg {desc="PRETIMEOUT_HI_ACTIVE_SNAP"; field {sw=r; hw=w; reset=0;} value_0[31:0];} PRETIMEOUT_HI_ACTIVE_SNAP @ 0x11c;
    external reg {desc="BOOT_TIMEOUT_LO_ACTIVE_SNAP"; field {sw=r; hw=w; reset=0;} value_0[31:0];} BOOT_TIMEOUT_LO_ACTIVE_SNAP @ 0x120;
    external reg {desc="BOOT_TIMEOUT_HI_ACTIVE_SNAP"; field {sw=r; hw=w; reset=0;} value_0[31:0];} BOOT_TIMEOUT_HI_ACTIVE_SNAP @ 0x124;
    external reg {desc="SEQ_LIMIT_ACTIVE_SNAP"; field {sw=r; hw=w; reset=0;} value_0[31:0];} SEQ_LIMIT_ACTIVE_SNAP @ 0x128;
    external reg {desc="REQUIRE_MASK_ACTIVE_SNAP"; field {sw=r; hw=w; reset=0;} value_0[31:0];} REQUIRE_MASK_ACTIVE_SNAP @ 0x12c;
    external reg {desc="FAULT_POLICY_ACTIVE_SNAP"; field {sw=r; hw=w; reset=0;} value_0[31:0];} FAULT_POLICY_ACTIVE_SNAP @ 0x130;
    external reg {desc="LOCAL_DELAY_ACTIVE_SNAP"; field {sw=r; hw=w; reset=0;} value_0[31:0];} LOCAL_DELAY_ACTIVE_SNAP @ 0x134;
    external reg {desc="FINAL_DELAY_ACTIVE_SNAP"; field {sw=r; hw=w; reset=0;} value_0[31:0];} FINAL_DELAY_ACTIVE_SNAP @ 0x138;
    external reg {desc="RECOVERY_LIMIT_ACTIVE_SNAP"; field {sw=r; hw=w; reset=0;} value_0[31:0];} RECOVERY_LIMIT_ACTIVE_SNAP @ 0x13c;
    external reg {desc="CLIENT_SELECT"; field {sw=rw; hw=r; reset=0;} value_0[4:0];} CLIENT_SELECT @ 0x140;
    external reg {desc="CLIENT_OWNER_STAGE"; field {sw=rw; hw=r; reset=0;} value_0[31:0];} CLIENT_OWNER_STAGE @ 0x144;
    external reg {desc="CLIENT_ALIVE_STAGE"; field {sw=rw; hw=r; reset=0;} value_0[31:0];} CLIENT_ALIVE_STAGE @ 0x148;
    external reg {desc="CLIENT_FLOW_STAGE"; field {sw=rw; hw=r; reset=0;} value_0[7:0];} CLIENT_FLOW_STAGE @ 0x14c;
    external reg {desc="CLIENT_DEADLINE_MIN_LO_STAGE"; field {sw=rw; hw=r; reset=0;} value_0[31:0];} CLIENT_DEADLINE_MIN_LO_STAGE @ 0x150;
    external reg {desc="CLIENT_DEADLINE_MIN_HI_STAGE"; field {sw=rw; hw=r; reset=0;} value_0[31:0];} CLIENT_DEADLINE_MIN_HI_STAGE @ 0x154;
    external reg {desc="CLIENT_DEADLINE_MAX_LO_STAGE"; field {sw=rw; hw=r; reset=0;} value_0[31:0];} CLIENT_DEADLINE_MAX_LO_STAGE @ 0x158;
    external reg {desc="CLIENT_DEADLINE_MAX_HI_STAGE"; field {sw=rw; hw=r; reset=0;} value_0[31:0];} CLIENT_DEADLINE_MAX_HI_STAGE @ 0x15c;
    external reg {desc="CLIENT_FLAGS_SNAP"; field {sw=r; hw=w; reset=0;} value_0[31:0];} CLIENT_FLAGS_SNAP @ 0x180;
    external reg {desc="CLIENT_TOKEN_SNAP"; field {sw=r; hw=w; reset=0;} value_0[31:0];} CLIENT_TOKEN_SNAP @ 0x184;
    external reg {desc="CLIENT_ALIVE_COUNT_SNAP"; field {sw=r; hw=w; reset=0;} value_0[31:0];} CLIENT_ALIVE_COUNT_SNAP @ 0x188;
    external reg {desc="CLIENT_ELAPSED_LO_SNAP"; field {sw=r; hw=w; reset=0;} value_0[31:0];} CLIENT_ELAPSED_LO_SNAP @ 0x18c;
    external reg {desc="CLIENT_ELAPSED_HI_SNAP"; field {sw=r; hw=w; reset=0;} value_0[31:0];} CLIENT_ELAPSED_HI_SNAP @ 0x190;
    external reg {desc="CLIENT_OWNER_ACTIVE_SNAP"; field {sw=r; hw=w; reset=0;} value_0[31:0];} CLIENT_OWNER_ACTIVE_SNAP @ 0x1a0;
    external reg {desc="CLIENT_ALIVE_ACTIVE_SNAP"; field {sw=r; hw=w; reset=0;} value_0[31:0];} CLIENT_ALIVE_ACTIVE_SNAP @ 0x1a4;
    external reg {desc="CLIENT_FLOW_ACTIVE_SNAP"; field {sw=r; hw=w; reset=0;} value_0[31:0];} CLIENT_FLOW_ACTIVE_SNAP @ 0x1a8;
    external reg {desc="CLIENT_DEADLINE_MIN_LO_ACTIVE_SNAP"; field {sw=r; hw=w; reset=0;} value_0[31:0];} CLIENT_DEADLINE_MIN_LO_ACTIVE_SNAP @ 0x1ac;
    external reg {desc="CLIENT_DEADLINE_MIN_HI_ACTIVE_SNAP"; field {sw=r; hw=w; reset=0;} value_0[31:0];} CLIENT_DEADLINE_MIN_HI_ACTIVE_SNAP @ 0x1b0;
    external reg {desc="CLIENT_DEADLINE_MAX_LO_ACTIVE_SNAP"; field {sw=r; hw=w; reset=0;} value_0[31:0];} CLIENT_DEADLINE_MAX_LO_ACTIVE_SNAP @ 0x1b4;
    external reg {desc="CLIENT_DEADLINE_MAX_HI_ACTIVE_SNAP"; field {sw=r; hw=w; reset=0;} value_0[31:0];} CLIENT_DEADLINE_MAX_HI_ACTIVE_SNAP @ 0x1b8;
  };
  channel_regs ch[16] @ 0x1000 += 0x400;
};
